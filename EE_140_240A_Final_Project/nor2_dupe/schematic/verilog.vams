// Verilog-AMS netlist generated by the AMS netlister, version 5.10.41.500.5.125.
// Cadence Design Systems, Inc.

`include "disciplines.vams"
`include "constants.vams"

(* cds_ams_schematic *)
module nor2 ( out,a,b );

output   out;
input   a;
input   b;

wire (*
integer inh_conn_prop_name = "ground_gnd";
integer
inh_conn_def_value = "cds_globals.\\gnd! ";
 *)
\gnd! ;
wire (*
integer inh_conn_prop_name = "power_vdd";
integer
inh_conn_def_value = "cds_globals.\\vdd! ";
 *)
\vdd! ;

parameter lc=2.7e-07;
parameter GT_PDW="";
parameter sx=4.8e-07;
parameter GT_PDL=180.00n;
parameter GT_PUW="";
parameter GT_PUL=180.00n;

ne #(.m(1 * 1), .ad(sx * GT_PDW), .nrd(lc / GT_PDW), .w(GT_PDW), .pd(2 * ( sx + GT_PDW )),
 .par1((1 * 1)), .as(sx * GT_PDW), .nrs(lc / GT_PDW), .ps(2 * ( sx + GT_PDW )),
 .l(GT_PDL)) (*
integer library_binding = "PRIMLIB";
integer
passed_mfactor = "m";
 *)
MN2 ( out, a, \gnd! , \gnd!  );
ne #(.m(1 * 1), .ad(sx * GT_PDW), .nrd(lc / GT_PDW), .w(GT_PDW), .pd(2 * ( sx + GT_PDW )),
 .par1((1 * 1)), .as(sx * GT_PDW), .nrs(lc / GT_PDW), .ps(2 * ( sx + GT_PDW )),
 .l(GT_PDL)) (*
integer library_binding = "PRIMLIB";
integer
passed_mfactor = "m";
 *)
MN1 ( out, b, \gnd! , \gnd!  );

pe #(.m(1 * 1), .ad(sx * GT_PUW), .nrd(lc / GT_PUW), .w(GT_PUW), .pd(2 * ( sx + GT_PUW )),
 .par1((1 * 1)), .as(sx * GT_PUW), .nrs(lc / GT_PUW), .ps(2 * ( sx + GT_PUW )),
 .l(GT_PUL)) (*
integer library_binding = "PRIMLIB";
integer
passed_mfactor = "m";
 *)
MP2 ( NETZ32, b, \vdd! , \vdd!  );
pe #(.m(1 * 1), .ad(sx * GT_PUW), .nrd(lc / GT_PUW), .w(GT_PUW), .pd(2 * ( sx + GT_PUW )),
 .par1((1 * 1)), .as(sx * GT_PUW), .nrs(lc / GT_PUW), .ps(2 * ( sx + GT_PUW )),
 .l(GT_PUL)) (*
integer library_binding = "PRIMLIB";
integer
passed_mfactor = "m";
 *)
MP1 ( out, a, NETZ32, \vdd!  );

endmodule
