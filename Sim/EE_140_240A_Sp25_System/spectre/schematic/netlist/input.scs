// Design: Test_EE_140_240A_Final_Project/EE_140_240A_Sp25_System
simulator lang=spectre
global 0
parameters C=4f _EXPR_7=2e-05 FCLK=1M G_0=1 G_1=0 G_2=0 NBAT=1.8 S_0=0 S_1=0 TRISE_BAT=100n TR_D=1u VBAT=1.6 VDDA_IDEAL=1.8 VDDD_IDEAL=1.8 VIN_0=200m VIN_1=1
include "/home/ff/ee140/fa19/xfab/XKIT/xt018/cadence/v8_0/spectre/v8_0_2/lp5mos/config.scs" section=default
include "/home/ff/ee140/fa19/xfab/XKIT/xt018/cadence/v8_0/spectre/v8_0_2/lp5mos/param.scs" section=3s
include "/home/ff/ee140/fa19/xfab/XKIT/xt018/cadence/v8_0/spectre/v8_0_2/lp5mos/bip.scs" section=tm
include "/home/ff/ee140/fa19/xfab/XKIT/xt018/cadence/v8_0/spectre/v8_0_2/lp5mos/cap.scs" section=tm
include "/home/ff/ee140/fa19/xfab/XKIT/xt018/cadence/v8_0/spectre/v8_0_2/lp5mos/dio.scs" section=tm
include "/home/ff/ee140/fa19/xfab/XKIT/xt018/cadence/v8_0/spectre/v8_0_2/lp5mos/mos.scs" section=tm
include "/home/ff/ee140/fa19/xfab/XKIT/xt018/cadence/v8_0/spectre/v8_0_2/lp5mos/res.scs" section=tm
include "/home/cc/ee140/sp25/staff/ee140-tab/cadence/cadence_finalproj/sky130_release_0.0.4/models/sky130.lib.spice" section=tt

// EE_140_240A_Final_Project/AND2HDX0_dupe/schematic
subckt AND2HDX0_dupe_schematic A B OUT VDD VSS
    ne (OUT net027 VSS VSS) ne w=420.0n l=180.0n m=(1)*(1)
    MN1 (net027 A net029 VSS) ne w=420.0n l=180.0n m=(1)*(1)
    MN2 (net029 B VSS VSS) ne w=420.0n l=180.0n m=(1)*(1)
    pe (OUT net027 VDD VDD) pe w=720.0n l=180.0n m=(1)*(1)
    MP1 (net027 A VDD VDD) pe w=720.0n l=180.0n m=(1)*(1)
    MP2 (net027 B VDD VDD) pe w=720.0n l=180.0n m=(1)*(1)
ends AND2HDX0_dupe_schematic

// EE_140_240A_Final_Project/invr_dupe/schematic
subckt invr_dupe_schematic in out VDD VSS
parameters GT_PDW GT_PDL=180.00n sx=4.8e-07 lc=2.7e-07 GT_PUW GT_PUL=180.00n
    ne (out in VSS VSS) ne w=GT_PDW l=GT_PDL m=(1)*(1)
    pe (out in VDD VDD) pe w=GT_PUW l=GT_PUL m=(1)*(1)
ends invr_dupe_schematic

// EE_140_240A_Final_Project/nor2_dupe/schematic
subckt nor2_dupe_schematic a b out VDD VSS
parameters GT_PDW GT_PDL=180.00n sx=4.8e-07 lc=2.7e-07 GT_PUW GT_PUL=180.00n
    MN1 (out b VSS VSS) ne w=GT_PDW l=GT_PDL m=(1)*(1)
    MN2 (out a VSS VSS) ne w=GT_PDW l=GT_PDL m=(1)*(1)
    MP1 (out a net14 VDD) pe w=GT_PUW l=GT_PUL m=(1)*(1)
    MP2 (net14 b VDD VDD) pe w=GT_PUW l=GT_PUL m=(1)*(1)
ends nor2_dupe_schematic

// EE_140_240A_Final_Project/OR2HDX0_dupe/schematic
subckt OR2HDX0_dupe_schematic A B OUT VDD VSS
    I1 (net11 OUT VDD VSS) invr_dupe_schematic GT_PDW=420n GT_PDL=180.00n sx=4.8e-07 lc=2.7e-07 GT_PUW=720n GT_PUL=180.00n
    I0 (A B net11 VDD VSS) nor2_dupe_schematic GT_PDW=420n GT_PDL=180.00n sx=4.8e-07 lc=2.7e-07 GT_PUW=720n GT_PUL=180.00n
ends OR2HDX0_dupe_schematic

// project/opamp_pga/schematic
subckt opamp_pga VDD VINN VINP VOUT VSS
    NM18 (net139 VG3 net1 VSS) nfet_01v8 w=(3u) l=300n m=(1)*(1)
    NM17 (VG5 VG3 net4 VSS) nfet_01v8 w=(3u) l=300n m=(1)*(1)
    NM16 (net4 VG2 VSS VSS) nfet_01v8 w=(6u) l=300n m=(1)*(1)
    NM15 (net1 VG2 VSS VSS) nfet_01v8 w=(6u) l=300n m=(1)*(1)
    NM14 (VG6 VG2 VSS VSS) nfet_01v8 w=(6u) l=300n m=(1)*(1)
    NM13 (VG2 VG2 VSS VSS) nfet_01v8 w=(6u) l=300n m=(1)*(1)
    NM12 (VG3 VG3 VSS VSS) nfet_01v8 w=(1.2u) l=300n m=(1)*(1)
    NM11 (VOUT VG2 VSS VSS) nfet_01v8 w=(6u) l=300n m=(1)*(1)
    PM18 (net2 VG5 VDD VDD) pfet_01v8 w=(12u) l=300n m=(1)*(1)
    PM17 (net6 VG5 VDD VDD) pfet_01v8 w=(12u) l=300n m=(1)*(1)
    PM16 (net5 VG6 VDD VDD) pfet_01v8 w=(6u) l=300n m=(1)*(1)
    PM15 (VG5 VG6 net6 VDD) pfet_01v8 w=(12u) l=300n m=(1)*(1)
    PM14 (net139 VG6 net2 VDD) pfet_01v8 w=(12u) l=300n m=(1)*(1)
    PM13 (VG6 VG6 VDD VDD) pfet_01v8 w=(6u) l=300n m=(1)*(1)
    PM12 (VG2 VG6 net3 VDD) pfet_01v8 w=(24u) l=300n m=(1)*(1)
    PM11 (VG3 VG6 VDD VDD) pfet_01v8 w=(6u) l=300n m=(1)*(1)
    PM10 (net1 VINN net5 VDD) pfet_01v8 w=(12u) l=300n m=(1)*(1)
    PM9 (net4 VINP net5 VDD) pfet_01v8 w=(12u) l=300n m=(1)*(1)
    PM8 (VOUT net139 VDD VDD) pfet_01v8 w=(30u) l=300n m=(1)*(1)
    R1 (VDD net3) resistor r=3.5K
ends opamp_pga

// swy/opamp_mockup/schematic
subckt swy_opamp_mockup_schematic VDD VINN VINP VOUT VSS
    I0 (VDD VINN VINP VOUT VSS) opamp_pga
ends swy_opamp_mockup_schematic

// swy/PGA_mockup/schematic
subckt swy_PGA_mockup_schematic CLK1 CLK2 G\<2\> G\<1\> G\<0\> VDD VIN VOUT VSS
    C8 (VOUT net2) capacitor c=5p
    C4 (net2 net5) capacitor c=20p
    C6 (net2 net3) capacitor c=5p
    C5 (net2 net4) capacitor c=10p
    C7 (net2 net1) capacitor c=5p
    I8 (G\<0\> CLK1 X\<0\> VDD VSS) AND2HDX0_dupe_schematic
    I2 (G\<1\> CLK1 X\<1\> VDD VSS) AND2HDX0_dupe_schematic
    I0 (G\<2\> CLK1 X\<2\> VDD VSS) AND2HDX0_dupe_schematic
    I12 (CLK2 GB\<2\> CLK2_GATE\<2\> VDD VSS) OR2HDX0_dupe_schematic
    I11 (CLK2 GB\<1\> CLK2_GATE\<1\> VDD VSS) OR2HDX0_dupe_schematic
    I6 (CLK2 GB\<0\> CLK2_GATE\<0\> VDD VSS) OR2HDX0_dupe_schematic
    I15 (CLK1 CLK1B VDD VSS) invr_dupe_schematic GT_PDW=420n GT_PDL=180.00n sx=4.8e-07 lc=2.7e-07 GT_PUW=720n GT_PUL=180.00n
    I14 (X\<0\> XB\<0\> VDD VSS) invr_dupe_schematic GT_PDW=420n GT_PDL=180.00n sx=4.8e-07 lc=2.7e-07 GT_PUW=720n GT_PUL=180.00n
    I7 (X\<1\> XB\<1\> VDD VSS) invr_dupe_schematic GT_PDW=420n GT_PDL=180.00n sx=4.8e-07 lc=2.7e-07 GT_PUW=720n GT_PUL=180.00n
    I1 (X\<2\> XB\<2\> VDD VSS) invr_dupe_schematic GT_PDW=420n GT_PDL=180.00n sx=4.8e-07 lc=2.7e-07 GT_PUW=720n GT_PUL=180.00n
    I13 (G\<2\> GB\<2\> VDD VSS) invr_dupe_schematic GT_PDW=420n GT_PDL=180.00n sx=4.8e-07 lc=2.7e-07 GT_PUW=720n GT_PUL=180.00n
    I9 (G\<0\> GB\<0\> VDD VSS) invr_dupe_schematic GT_PDW=420n GT_PDL=180.00n sx=4.8e-07 lc=2.7e-07 GT_PUW=720n GT_PUL=180.00n
    I10 (G\<1\> GB\<1\> VDD VSS) invr_dupe_schematic GT_PDW=420n GT_PDL=180.00n sx=4.8e-07 lc=2.7e-07 GT_PUW=720n GT_PUL=180.00n
    NM5 (VSS CLK2 net1 VSS) nfet_01v8 w=(1u) l=150n m=(1)*(1)
    NM3 (net1 CLK1 VIN VSS) nfet_01v8 w=(1u) l=150n m=(1)*(1)
    NM17 (VSS CLK1 VOUT VSS) nfet_01v8 w=(3u) l=150n m=(1)*(1)
    NM8 (VSS CLK2_GATE\<2\> net5 VSS) nfet_01v8 w=(1u) l=150n m=(1)*(1)
    NM1 (net4 X\<1\> VIN VSS) nfet_01v8 w=(1u) l=150n m=(1)*(1)
    NM2 (net3 X\<0\> VIN VSS) nfet_01v8 w=(1u) l=150n m=(1)*(1)
    NM0 (net5 X\<2\> VIN VSS) nfet_01v8 w=(1u) l=150n m=(1)*(1)
    NM7 (VSS CLK2_GATE\<1\> net4 VSS) nfet_01v8 w=(1u) l=150n m=(1)*(1)
    NM18 (VSS CLK1 net2 VSS) nfet_01v8 w=(3u) l=150n m=(1)*(1)
    NM6 (VSS CLK2_GATE\<0\> net3 VSS) nfet_01v8 w=(1u) l=150n m=(1)*(1)
    I17 (VDD VSS net2 VOUT VSS) swy_opamp_mockup_schematic
    PM11 (VSS CLK1B VOUT VDD) pfet_01v8 w=(6u) l=150n m=(1)*(1)
    PM0 (net5 XB\<2\> VIN VDD) pfet_01v8 w=(2u) l=150n m=(1)*(1)
    PM1 (net4 XB\<1\> VIN VDD) pfet_01v8 w=(2u) l=150n m=(1)*(1)
    PM2 (net3 XB\<0\> VIN VDD) pfet_01v8 w=(2u) l=150n m=(1)*(1)
    PM12 (VSS CLK1B net2 VDD) pfet_01v8 w=(6u) l=150n m=(1)*(1)
    PM3 (net1 CLK1B VIN VDD) pfet_01v8 w=(2u) l=150n m=(1)*(1)
ends swy_PGA_mockup_schematic

// proj/inverter_adc/schematic
subckt inverter_adc out GND VDD in
    NM0 (out in GND GND) nfet_01v8 w=(420n) l=150n m=(1)*(1)
    PM0 (out in VDD VDD) pfet_01v8 w=(840n) l=150n m=(1)*(1)
ends inverter_adc

// proj/MUX21/schematic
subckt MUX21 out GND VDDA a0 a1 sel
    PM2 (a0 sel out VDDA) pfet_01v8 w=(550n) l=150n m=(1)*(1)
    PM0 (a1 sel_n out VDDA) pfet_01v8 w=(550n) l=150n m=(1)*(1)
    NM2 (a0 sel_n out GND) nfet_01v8 w=(420n) l=150n m=(1)*(1)
    NM0 (a1 sel out GND) nfet_01v8 w=(420n) l=150n m=(1)*(1)
    I0 (sel_n GND VDDA sel) inverter_adc
ends MUX21

// proj/MUX41/schematic
subckt MUX41 OUT GND VDDA VPTAT VBATdiv4 a0 a1 s0 s1
    I2 (OUT GND VDDA net2 net3 s1) MUX21
    I1 (net2 GND VDDA a0 a1 s0) MUX21
    I0 (net3 GND VDDA VBATdiv4 VPTAT s0) MUX21
ends MUX41

// EE_140_240A_Final_Project/mux_mockup/schematic
subckt mux_mockup_schematic IN\<3\> IN\<2\> IN\<1\> IN\<0\> OUT S\<1\> S\<0\> VDD VSS
    I2 (OUT VSS VDD IN\<3\> IN\<2\> IN\<0\> IN\<1\> S\<0\> S\<1\>) MUX41
ends mux_mockup_schematic

// lab6/5T/schematic
subckt lab6_5T_schematic Vout V\+ V\- Vin
    NM0 (Vout V\- net6 0) nfet_g5v0d10v5 w=(6u) l=600n m=(1)*(1)
    NM2 (net7 V\+ net6 0) nfet_g5v0d10v5 w=(6u) l=600n m=(1)*(1)
    NM1 (net6 net2 0 0) nfet_g5v0d10v5 w=(12u) l=600n m=(1)*(1)
    NM4 (net4 net2 0 0) nfet_g5v0d10v5 w=(6u) l=600n m=(1)*(1)
    NM3 (net2 net2 0 0) nfet_g5v0d10v5 w=(6u) l=600n m=(1)*(1)
    R0 (Vin net3) resistor r=54K
    PM1 (net7 net7 Vin Vin) pfet_g5v0d10v5 w=(6u) l=600n m=(1)*(1)
    PM0 (Vout net7 Vin Vin) pfet_g5v0d10v5 w=(6u) l=600n m=(1)*(1)
    PM3 (net2 net4 net3 Vin) pfet_g5v0d10v5 w=(24u) l=600n m=(1)*(1)
    PM2 (net4 net4 Vin Vin) pfet_g5v0d10v5 w=(6u) l=600n m=(1)*(1)
ends lab6_5T_schematic

// project/bandgap/schematic
subckt bandgap VBAT VBG VPTAT VREF_ADC VSS
    E0 (net2 VSS VBG VSS) vcvs gain=1 min=0 max=3.2
    Q1 (net1 net1 VSS VSS) npn_05v5_W1p00L1p00 area=1p m=10
    Q0 (VD1 VD1 VSS VSS) npn_05v5_W1p00L1p00 area=1p m=1
    R8 (VREF_ADC VSS) resistor r=5K
    R7 (net2 VREF_ADC) resistor r=1K
    R2 (VPTAT VSS) resistor r=64K
    R0 (VBG VD2) resistor r=47K
    R1 (VD2 net1) resistor r=6K
    I2 (net4 VD2 VD1 VBAT) lab6_5T_schematic
    PM2 (VPTAT net4 VBAT VBAT) pfet_g5v0d10v5 w=(6u) l=600n m=(1)*(1)
    PM1 (VD1 net4 VBAT VBAT) pfet_g5v0d10v5 w=(6u) l=600n m=(1)*(1)
    PM0 (VBG net4 VBAT VBAT) pfet_g5v0d10v5 w=(6u) l=600n m=(1)*(1)
ends bandgap

// swy/BGR_mockup/schematic
subckt swy_BGR_mockup_schematic VBAT VBG VPTAT VREF_ADC VSS
    I0 (VBAT VBG VPTAT VREF_ADC VSS) bandgap
ends swy_BGR_mockup_schematic

// swy/AREG_mockup/schematic
subckt swy_AREG_mockup_schematic VBAT VDDA VREF VSS
    R5 (VBAT VDDA) resistor r=10K
    R4 (VDDA net2) resistor r=1K
    R2 (net2 VSS) resistor r=2K
    C3 (VDDA VSS) capacitor c=1n
    C5 (net1 VSS) capacitor c=100p
    PM1 (VDDA net1 VBAT VBAT) pfet_g5v0d10v5 w=(50u) l=500n m=(50)*(1)
    E1 (net1 VSS net2 VREF) vcvs gain=1000 min=0 max=3.2
ends swy_AREG_mockup_schematic

// swy/DREG_mockup/schematic
subckt swy_DREG_mockup_schematic VBAT VDDA VREF VSS
    R5 (VBAT VDDA) resistor r=10K
    R4 (VDDA net2) resistor r=1K
    R2 (net2 VSS) resistor r=2K
    C3 (VDDA VSS) capacitor c=1n
    C5 (net1 VSS) capacitor c=100p
    PM1 (VDDA net1 VBAT VBAT) pfet_g5v0d10v5 w=(50u) l=500n m=(50)*(1)
    E1 (net1 VSS net2 VREF) vcvs gain=1000 min=0 max=3.2
ends swy_DREG_mockup_schematic

// EE_140_240A_Final_Project/VBATDIV4_mockup/schematic
subckt VBATDIV4_mockup_schematic VBAT VBATDIV4 VSS
    R0 (VBAT VBATDIV4) resistor r=24K
    R1 (VBATDIV4 VSS) resistor r=8K
ends VBATDIV4_mockup_schematic

// proj/TG/schematic
subckt TG GND S Sbar VDD Vin Vout
    NM0 (Vin S Vout GND) nfet_01v8 w=(550n) l=150n m=(1)*(1)
    PM0 (Vin Sbar Vout VDD) pfet_01v8 w=(550n) l=150n m=(1)*(1)
ends TG

// proj/switch_TG/schematic
subckt switch_TG Vout GND VDD sel Vin
    I0 (GND sel s_bar VDD Vin Vout) TG
    I1 (s_bar GND VDD sel) inverter_adc
ends switch_TG

// EE_140_240A_Final_Project/capdac_mockup/schematic
subckt capdac_mockup_schematic D\<7\> D\<6\> D\<5\> D\<4\> D\<3\> D\<2\> D\<1\> D\<0\> LOAD VDAC VDD VIN VREF VSS COMPARE
    C8 (VDAC BOT\<7\>) capacitor c=C m=128
    C7 (VDAC BOT\<6\>) capacitor c=C m=64
    C6 (VDAC BOT\<5\>) capacitor c=C m=32
    C5 (VDAC BOT\<4\>) capacitor c=C m=16
    C4 (VDAC BOT\<3\>) capacitor c=C m=8
    C3 (VDAC BOT\<2\>) capacitor c=C m=4
    C2 (VDAC BOT\<1\>) capacitor c=C m=2
    C1 (VDAC BOT\<0\>) capacitor c=C m=1
    C0 (VDAC BOTX) capacitor c=C m=1
    I17 (net031 D_SHIFT\<7\> VREF_SHIFT VSS) invr_dupe_schematic GT_PDW=420n GT_PDL=180.00n sx=4.8e-07 lc=2.7e-07 GT_PUW=720n GT_PUL=180.00n
    I16 (net032 D_SHIFT\<6\> VREF_SHIFT VSS) invr_dupe_schematic GT_PDW=420n GT_PDL=180.00n sx=4.8e-07 lc=2.7e-07 GT_PUW=720n GT_PUL=180.00n
    I15 (D\<7\> net031 VREF_SHIFT VSS) invr_dupe_schematic GT_PDW=420n GT_PDL=180.00n sx=4.8e-07 lc=2.7e-07 GT_PUW=720n GT_PUL=180.00n
    I14 (D\<6\> net032 VREF_SHIFT VSS) invr_dupe_schematic GT_PDW=420n GT_PDL=180.00n sx=4.8e-07 lc=2.7e-07 GT_PUW=720n GT_PUL=180.00n
    I13 (net033 D_SHIFT\<5\> VREF_SHIFT VSS) invr_dupe_schematic GT_PDW=420n GT_PDL=180.00n sx=4.8e-07 lc=2.7e-07 GT_PUW=720n GT_PUL=180.00n
    I12 (net034 D_SHIFT\<4\> VREF_SHIFT VSS) invr_dupe_schematic GT_PDW=420n GT_PDL=180.00n sx=4.8e-07 lc=2.7e-07 GT_PUW=720n GT_PUL=180.00n
    I11 (D\<5\> net033 VREF_SHIFT VSS) invr_dupe_schematic GT_PDW=420n GT_PDL=180.00n sx=4.8e-07 lc=2.7e-07 GT_PUW=720n GT_PUL=180.00n
    I10 (D\<4\> net034 VREF_SHIFT VSS) invr_dupe_schematic GT_PDW=420n GT_PDL=180.00n sx=4.8e-07 lc=2.7e-07 GT_PUW=720n GT_PUL=180.00n
    I9 (net035 D_SHIFT\<3\> VREF_SHIFT VSS) invr_dupe_schematic GT_PDW=420n GT_PDL=180.00n sx=4.8e-07 lc=2.7e-07 GT_PUW=720n GT_PUL=180.00n
    I8 (net036 D_SHIFT\<2\> VREF_SHIFT VSS) invr_dupe_schematic GT_PDW=420n GT_PDL=180.00n sx=4.8e-07 lc=2.7e-07 GT_PUW=720n GT_PUL=180.00n
    I7 (D\<3\> net035 VREF_SHIFT VSS) invr_dupe_schematic GT_PDW=420n GT_PDL=180.00n sx=4.8e-07 lc=2.7e-07 GT_PUW=720n GT_PUL=180.00n
    I6 (D\<2\> net036 VREF_SHIFT VSS) invr_dupe_schematic GT_PDW=420n GT_PDL=180.00n sx=4.8e-07 lc=2.7e-07 GT_PUW=720n GT_PUL=180.00n
    I5 (net07 D_SHIFT\<1\> VREF_SHIFT VSS) invr_dupe_schematic GT_PDW=420n GT_PDL=180.00n sx=4.8e-07 lc=2.7e-07 GT_PUW=720n GT_PUL=180.00n
    I4 (net08 D_SHIFT\<0\> VREF_SHIFT VSS) invr_dupe_schematic GT_PDW=420n GT_PDL=180.00n sx=4.8e-07 lc=2.7e-07 GT_PUW=720n GT_PUL=180.00n
    I3 (D\<1\> net07 VREF_SHIFT VSS) invr_dupe_schematic GT_PDW=420n GT_PDL=180.00n sx=4.8e-07 lc=2.7e-07 GT_PUW=720n GT_PUL=180.00n
    I2 (D\<0\> net08 VREF_SHIFT VSS) invr_dupe_schematic GT_PDW=420n GT_PDL=180.00n sx=4.8e-07 lc=2.7e-07 GT_PUW=720n GT_PUL=180.00n
    E8 (D_BUF\<7\> VSS D_SHIFT\<7\> VSS) vcvs gain=1.0
    E7 (D_BUF\<6\> VSS D_SHIFT\<6\> VSS) vcvs gain=1.0
    E6 (D_BUF\<5\> VSS D_SHIFT\<5\> VSS) vcvs gain=1.0
    E5 (D_BUF\<4\> VSS D_SHIFT\<4\> VSS) vcvs gain=1.0
    E4 (D_BUF\<3\> VSS D_SHIFT\<3\> VSS) vcvs gain=1.0
    E3 (D_BUF\<2\> VSS D_SHIFT\<2\> VSS) vcvs gain=1.0
    E2 (D_BUF\<1\> VSS D_SHIFT\<1\> VSS) vcvs gain=1.0
    E1 (D_BUF\<0\> VSS D_SHIFT\<0\> VSS) vcvs gain=1.0
    E0 (VREF_SHIFT VSS VREF VSS) vcvs gain=1.0 type=vcvs
    I48 (BOTX VSS VDD COMPARE VSS) switch_TG
    I47 (BOT\<1\> VSS VDD COMPARE D_BUF\<1\>) switch_TG
    I46 (BOT\<0\> VSS VDD COMPARE D_BUF\<0\>) switch_TG
    I45 (BOT\<2\> VSS VDD COMPARE D_BUF\<2\>) switch_TG
    I44 (BOT\<3\> VSS VDD COMPARE D_BUF\<3\>) switch_TG
    I25 (BOT\<5\> VSS VDD COMPARE D_BUF\<5\>) switch_TG
    I24 (BOT\<4\> VSS VDD COMPARE D_BUF\<4\>) switch_TG
    I23 (BOT\<7\> VSS VDD COMPARE D_BUF\<7\>) switch_TG
    I22 (BOT\<6\> VSS VDD COMPARE D_BUF\<6\>) switch_TG
    I43 (BOT\<7\> VSS VDD LOAD VIN) switch_TG
    I42 (BOT\<4\> VSS VDD LOAD VIN) switch_TG
    I41 (BOT\<5\> VSS VDD LOAD VIN) switch_TG
    I40 (BOT\<6\> VSS VDD LOAD VIN) switch_TG
    I39 (BOT\<3\> VSS VDD LOAD VIN) switch_TG
    I38 (BOT\<2\> VSS VDD LOAD VIN) switch_TG
    I37 (BOT\<0\> VSS VDD LOAD VIN) switch_TG
    I36 (BOT\<1\> VSS VDD LOAD VIN) switch_TG
    I35 (BOTX VSS VDD LOAD VIN) switch_TG
    I19 (VDAC VSS VDD LOAD VREF) switch_TG
ends capdac_mockup_schematic

// proj/strongARM_latch/schematic
subckt strongARM_latch X Y GND VDDA CK Vin1 Vin2
    PM5 (net4 CK VDDA VDDA) pfet_01v8 w=(600n) l=300n m=(1)*(1)
    PM4 (Y CK VDDA VDDA) pfet_01v8 w=(550n) l=225n m=(1)*(1)
    PM3 (X Y VDDA VDDA) pfet_01v8 w=(550n) l=225n m=(1)*(1)
    PM2 (Y X VDDA VDDA) pfet_01v8 w=(550n) l=225n m=(1)*(1)
    PM1 (X CK VDDA VDDA) pfet_01v8 w=(550n) l=225n m=(1)*(1)
    PM0 (net3 CK VDDA VDDA) pfet_01v8 w=(550n) l=225n m=(1)*(1)
    NM4 (net4 Vin2 net5 GND) nfet_01v8 w=(420n) l=210n m=(1)*(1)
    NM3 (X Y net3 GND) nfet_01v8 w=(420n) l=210n m=(1)*(1)
    NM2 (Y X net4 GND) nfet_01v8 w=(420n) l=210n m=(1)*(1)
    NM1 (net3 Vin1 net5 GND) nfet_01v8 w=(420n) l=210n m=(1)*(1)
    NM0 (net5 CK GND GND) nfet_01v8 w=(420n) l=210n m=(1)*(1)
ends strongARM_latch

// proj/comparator/schematic
subckt comparator OUT GND VDDA CK Vin1 Vin2
    I0 (net5 net4 GND VDDA CK Vin1 Vin2) strongARM_latch
    I4 (net13 GND VDDA OUT) inverter_adc
    I3 (OUT GND VDDA net13) inverter_adc
    I2 (net12 GND VDDA net4) inverter_adc
    I1 (net9 GND VDDA net5) inverter_adc
    NM1 (OUT net12 GND GND) nfet_01v8 w=(420n) l=150n m=(1)*(1)
    NM0 (net13 net9 GND GND) nfet_01v8 w=(420n) l=150n m=(1)*(1)
ends comparator

// EE_140_240A_Final_Project/ADC_mockup/schematic
subckt ADC_mockup_schematic CLK COMP_OUT D\<7\> D\<6\> D\<5\> D\<4\> D\<3\> D\<2\> D\<1\> D\<0\> VDD VIN VREF VSS COMPARE LOAD VDAC
    X_CAPDAC (D\<7\> D\<6\> D\<5\> D\<4\> D\<3\> D\<2\> D\<1\> D\<0\> LOAD VDAC VDD VIN VREF VSS COMPARE) capdac_mockup_schematic
    I3 (net1 VSS VDD CLK) inverter_adc
    I2 (COMP_OUT VSS VDD net1 VREF VDAC) comparator
ends ADC_mockup_schematic

// EE_140_240A_Final_Project/EE_140_240A_Sp25_Student_Submission/schematic
subckt EE_140_240A_Sp25_Student_Submission_schematic CLK_ADC CLK_PGA1 CLK_PGA2 COMP D\<7\> D\<6\> D\<5\> D\<4\> D\<3\> D\<2\> D\<1\> D\<0\> EXT_IN\<0\> EXT_IN\<1\> G\<2\> G\<1\> G\<0\> S\<1\> S\<0\> VBAT VBATDIV4 VDAC VDDA VDDD VPTAT VSS
    I13 (CLK_PGA1 CLK_PGA2 G\<2\> G\<1\> G\<0\> VDDA MUX_OUT PGA_OUT VSS) swy_PGA_mockup_schematic
    X_MUX (VPTAT VBATDIV4 EXT_IN\<1\> EXT_IN\<0\> MUX_OUT S\<1\> S\<0\> VDDA VSS) mux_mockup_schematic
    I8 (VBAT VREF_REG VPTAT VREF_ADC VSS) swy_BGR_mockup_schematic
    I9 (VBAT VDDA VREF_REG VSS) swy_AREG_mockup_schematic
    I10 (VBAT VDDD VREF_REG VSS) swy_DREG_mockup_schematic
    X_DIV4 (VBAT VBATDIV4 VSS) VBATDIV4_mockup_schematic
    X_ADC (CLK_ADC COMP D\<7\> D\<6\> D\<5\> D\<4\> D\<3\> D\<2\> D\<1\> D\<0\> VDDA PGA_OUT VREF_ADC VSS CLK_PGA1 CLK_PGA2 VDAC) ADC_mockup_schematic
ends EE_140_240A_Sp25_Student_Submission_schematic

// EE_140_240A_Final_Project/NA2HDX0_dupe/schematic
subckt NA2HDX0_dupe_schematic A B Q VDD VSS
    MN1 (Q A net44 VSS) ne w=420.0n l=180.0n m=(1)*(1)
    MN2 (net44 B VSS VSS) ne w=420.0n l=180.0n m=(1)*(1)
    MP1 (Q A VDD VDD) pe w=720.0n l=180.0n m=(1)*(1)
    MP2 (Q B VDD VDD) pe w=720.0n l=180.0n m=(1)*(1)
ends NA2HDX0_dupe_schematic

// EE_140_240A_Final_Project/clk_nonoverlapping/schematic
subckt clk_nonoverlapping_schematic CLK_IN PHI1 PHI2 VDD VSS
    I7 (net09 net5 net1 VDD VSS) NA2HDX0_dupe_schematic
    I0 (CLK_IN net08 net4 VDD VSS) NA2HDX0_dupe_schematic
    C5 (net08 VSS) capacitor c=100f
    C4 (net09 VSS) capacitor c=100f
    C3 (net3 VSS) capacitor c=100f
    C2 (net4 VSS) capacitor c=100f
    C1 (net2 VSS) capacitor c=100f
    C0 (net1 VSS) capacitor c=100f
    I9 (net08 PHI2 VDD VSS) invr_dupe_schematic GT_PDW=420n GT_PDL=180.00n sx=4.8e-07 lc=2.7e-07 GT_PUW=720n GT_PUL=180.00n
    I8 (net09 PHI1 VDD VSS) invr_dupe_schematic GT_PDW=420n GT_PDL=180.00n sx=4.8e-07 lc=2.7e-07 GT_PUW=720n GT_PUL=180.00n
    I6 (CLK_IN net5 VDD VSS) invr_dupe_schematic GT_PDW=420n GT_PDL=180.00n sx=4.8e-07 lc=2.7e-07 GT_PUW=720n GT_PUL=180.00n
    I5 (net3 net09 VDD VSS) invr_dupe_schematic GT_PDW=420n GT_PDL=180.00n sx=4.8e-07 lc=2.7e-07 GT_PUW=720n GT_PUL=180.00n
    I4 (net2 net08 VDD VSS) invr_dupe_schematic GT_PDW=420n GT_PDL=180.00n sx=4.8e-07 lc=2.7e-07 GT_PUW=720n GT_PUL=180.00n
    I3 (net1 net2 VDD VSS) invr_dupe_schematic GT_PDW=420n GT_PDL=180.00n sx=4.8e-07 lc=2.7e-07 GT_PUW=720n GT_PUL=180.00n
    I2 (net4 net3 VDD VSS) invr_dupe_schematic GT_PDW=420n GT_PDL=180.00n sx=4.8e-07 lc=2.7e-07 GT_PUW=720n GT_PUL=180.00n
ends clk_nonoverlapping_schematic

// EE_140_240A_Final_Project/DFRRSHDX0_dupe/schematic
subckt DFRRSHDX0_dupe_schematic C D Q QN RN SN VDD VSS
    MN10 (SQIB CI net268 VSS) ne w=420.0n l=180.0n m=(1)*(1)
    MN14 (SQIB CIB net266 VSS) ne w=420.0n l=180.0n m=(1)*(1)
    MN2 (MQIB CIB net271 VSS) ne w=420.0n l=180.0n m=(1)*(1)
    MN6 (MQIB CI net270 VSS) ne w=420.0n l=180.0n m=(1)*(1)
    MN13 (net266 SQI net265 VSS) ne w=420.0n l=180.0n m=(1)*(1)
    MN7 (MQI MQIB net269 VSS) ne w=505.00n l=180.0n m=(1)*(1)
    MN15 (SQI SQIB net264 VSS) ne w=890.0n l=180.0n m=(1)*(1)
    MN9 (net268 MQI net267 VSS) ne w=420.0n l=180.0n m=(1)*(1)
    MN1 (net271 D net273 VSS) ne w=420.0n l=180.0n m=(1)*(1)
    MN5 (net270 MQI net272 VSS) ne w=420.0n l=180.0n m=(1)*(1)
    MN11 (net267 RN VSS VSS) ne w=420.0n l=180.0n m=(1)*(1)
    MN16 (net264 SN VSS VSS) ne w=890.0n l=180.0n m=(1)*(1)
    MN12 (net265 RN VSS VSS) ne w=420.0n l=180.0n m=(1)*(1)
    MN8 (net269 SN VSS VSS) ne w=505.00n l=180.0n m=(1)*(1)
    MN3 (net273 RN VSS VSS) ne w=420.0n l=180.0n m=(1)*(1)
    MN4 (net272 RN VSS VSS) ne w=420.0n l=180.0n m=(1)*(1)
    MP3 (MQIB RN VDD VDD) pe w=955.00n l=180.0n m=(1)*(1)
    MP14 (SQI SN VDD VDD) pe w=925.00n l=180.0n m=(1)*(1)
    MP10 (SQIB RN VDD VDD) pe w=505.00n l=180.0n m=(1)*(1)
    MP6 (MQI MQIB VDD VDD) pe w=850.0n l=180.0n m=(1)*(1)
    MP9 (net261 MQI VDD VDD) pe w=715.00n l=180.0n m=(1)*(1)
    MP7 (MQI SN VDD VDD) pe w=850.0n l=180.0n m=(1)*(1)
    MP13 (SQI SQIB VDD VDD) pe w=925.00n l=180.0n m=(1)*(1)
    MP12 (net260 SQI VDD VDD) pe w=420.0n l=180.0n m=(1)*(1)
    MP5 (net262 MQI VDD VDD) pe w=420.0n l=180.0n m=(1)*(1)
    MP2 (net263 D VDD VDD) pe w=705.00n l=180.0n m=(1)*(1)
    MP11 (SQIB CI net260 VDD) pe w=420.0n l=180.0n m=(1)*(1)
    MP4 (MQIB CIB net262 VDD) pe w=420.0n l=180.0n m=(1)*(1)
    MP8 (SQIB CIB net261 VDD) pe w=715.00n l=180.0n m=(1)*(1)
    MP1 (MQIB CI net263 VDD) pe w=705.00n l=180.0n m=(1)*(1)
    I0 (C CIB VDD VSS) invr_dupe_schematic GT_PDW=420.0n GT_PDL=180.00n sx=4.8e-07 lc=2.7e-07 GT_PUW=720.00n GT_PUL=180.00n
    I2 (SQI QN VDD VSS) invr_dupe_schematic GT_PDW=420.0n GT_PDL=180.00n sx=4.8e-07 lc=2.7e-07 GT_PUW=720.00n GT_PUL=180.00n
    I1 (CIB CI VDD VSS) invr_dupe_schematic GT_PDW=420.0n GT_PDL=180.00n sx=4.8e-07 lc=2.7e-07 GT_PUW=720.00n GT_PUL=180.00n
    I3 (SQIB Q VDD VSS) invr_dupe_schematic GT_PDW=420.0n GT_PDL=180.00n sx=4.8e-07 lc=2.7e-07 GT_PUW=720.00n GT_PUL=180.00n
ends DFRRSHDX0_dupe_schematic

// EE_140_240A_Final_Project/SAR_DFF/schematic
subckt SAR_DFF_schematic CLK COMP D\<7\> D\<6\> D\<5\> D\<4\> D\<3\> D\<2\> D\<1\> D\<0\> RESETB DONE VDD VSS
    I18 (VSS VSS DONE net019 RESETB net010 VDD VSS) DFRRSHDX0_dupe_schematic
    I17 (DONE COMP D\<0\> net067 RESETB net014 VDD VSS) DFRRSHDX0_dupe_schematic
    I16 (D\<0\> COMP D\<1\> net025 RESETB net018 VDD VSS) DFRRSHDX0_dupe_schematic
    I15 (D\<1\> COMP D\<2\> net029 RESETB net022 VDD VSS) DFRRSHDX0_dupe_schematic
    I14 (D\<2\> COMP D\<3\> net033 RESETB net026 VDD VSS) DFRRSHDX0_dupe_schematic
    I13 (D\<3\> COMP D\<4\> net065 RESETB net030 VDD VSS) DFRRSHDX0_dupe_schematic
    I12 (D\<4\> COMP D\<5\> net043 RESETB net034 VDD VSS) DFRRSHDX0_dupe_schematic
    I11 (D\<5\> COMP D\<6\> net048 RESETB net038 VDD VSS) DFRRSHDX0_dupe_schematic
    I10 (D\<6\> COMP D\<7\> net053 RESETB net2 VDD VSS) DFRRSHDX0_dupe_schematic
    I8 (CLK X\<0\> net09 net010 RESETB VDD VDD VSS) DFRRSHDX0_dupe_schematic
    I7 (CLK X\<1\> X\<0\> net014 RESETB VDD VDD VSS) DFRRSHDX0_dupe_schematic
    I6 (CLK X\<2\> X\<1\> net018 RESETB VDD VDD VSS) DFRRSHDX0_dupe_schematic
    I5 (CLK X\<3\> X\<2\> net022 RESETB VDD VDD VSS) DFRRSHDX0_dupe_schematic
    I4 (CLK X\<4\> X\<3\> net026 RESETB VDD VDD VSS) DFRRSHDX0_dupe_schematic
    I3 (CLK X\<5\> X\<4\> net030 RESETB VDD VDD VSS) DFRRSHDX0_dupe_schematic
    I2 (CLK X\<6\> X\<5\> net034 RESETB VDD VDD VSS) DFRRSHDX0_dupe_schematic
    I1 (CLK X\<7\> X\<6\> net038 RESETB VDD VDD VSS) DFRRSHDX0_dupe_schematic
    I0 (CLK VSS X\<7\> net2 VDD RESETB VDD VSS) DFRRSHDX0_dupe_schematic
ends SAR_DFF_schematic

// EE_140_240A_Final_Project/mux2_mockup/schematic
subckt mux2_mockup_schematic IN\<1\> IN\<0\> S VDD VOUT VSS
    W1 (IN\<1\> VOUT S VSS) relay vt1=100m vt2=600m ropen=1T rclosed=10
    W0 (IN\<0\> VOUT Sb VSS) relay vt1=100m vt2=600m ropen=1T rclosed=10
    I0 (S Sb VDD VSS) invr_dupe_schematic GT_PDW=420n GT_PDL=180.00n sx=4.8e-07 lc=2.7e-07 GT_PUW=720n GT_PUL=180.00n
ends mux2_mockup_schematic

// EE_140_240A_Final_Project/XNOR_gate/schematic
subckt XNOR_gate_schematic A B OUT VDD VSS
    I2 (A B net5 VDD VSS) AND2HDX0_dupe_schematic
    I1 (net3 net2 net4 VDD VSS) AND2HDX0_dupe_schematic
    I4 (B net2 VDD VSS) invr_dupe_schematic GT_PDW=420n GT_PDL=180.00n sx=4.8e-07 lc=2.7e-07 GT_PUW=720n GT_PUL=180.00n
    I3 (A net3 VDD VSS) invr_dupe_schematic GT_PDW=420n GT_PDL=180.00n sx=4.8e-07 lc=2.7e-07 GT_PUW=720n GT_PUL=180.00n
    I0 (net4 net5 OUT VDD VSS) OR2HDX0_dupe_schematic
ends XNOR_gate_schematic

// EE_140_240A_Final_Project/SAR_FSM_HW/schematic
subckt SAR_FSM_HW_schematic VDD VSS adc_convert adc_done adc_resetb clk clk_dff clk_pga run_conversion
    I28 (VSS net11 net12 VDD next_state\<1\> VSS) mux2_mockup_schematic
    I6 (VDD VSS M_SEL_CONV\<1\> VDD adc_convert VSS) mux2_mockup_schematic
    I4 (VSS VDD net12 VDD clk_pga VSS) mux2_mockup_schematic
    I3 (VSS VDD net12 VDD adc_resetb VSS) mux2_mockup_schematic
    I2 (VDD net14 net12 VDD next_state\<0\> VSS) mux2_mockup_schematic
    I32 (VSS VSS net15 net13 next_state\<1\> M_SEL_CONV\<1\> M_SEL_CONV\<0\> VDD VSS) mux_mockup_schematic
    I25 (VDD VSS net10 net9 next_state\<1\> M_SEL_IDLE\<1\> M_SEL_IDLE\<0\> VDD VSS) mux_mockup_schematic
    I8 (VSS VSS net46 net41 next_state\<0\> M_SEL_IDLE\<1\> M_SEL_IDLE\<0\> VDD VSS) mux_mockup_schematic
    I7 (VSS VDD net32 net27 next_state\<0\> M_SEL_CONV\<1\> M_SEL_CONV\<0\> VDD VSS) mux_mockup_schematic
    I38 (clk adc_convert clk_dff VDD VSS) AND2HDX0_dupe_schematic
    I24 (VDD run_conversion M_SEL_IDLE\<0\> VDD VSS) AND2HDX0_dupe_schematic
    I23 (VDD adc_done M_SEL_CONV\<0\> VDD VSS) AND2HDX0_dupe_schematic
    I11 (net63 net62 M_SEL_CONV\<1\> VDD VSS) AND2HDX0_dupe_schematic
    I10 (net58 net57 net12 VDD VSS) AND2HDX0_dupe_schematic
    I9 (net53 net52 M_SEL_IDLE\<1\> VDD VSS) AND2HDX0_dupe_schematic
    I17 (S\<0\> VDD net63 VDD VSS) XNOR_gate_schematic
    I16 (S\<1\> VSS net62 VDD VSS) XNOR_gate_schematic
    I15 (S\<1\> VDD net57 VDD VSS) XNOR_gate_schematic
    I14 (S\<0\> VSS net58 VDD VSS) XNOR_gate_schematic
    I13 (S\<1\> VSS net52 VDD VSS) XNOR_gate_schematic
    I12 (S\<0\> VSS net53 VDD VSS) XNOR_gate_schematic
    I36 (clk next_state\<1\> S\<1\> net1 VDD VDD VDD VSS) DFRRSHDX0_dupe_schematic
    I0 (clk next_state\<0\> S\<0\> net5 VDD VDD VDD VSS) DFRRSHDX0_dupe_schematic
ends SAR_FSM_HW_schematic

// EE_140_240A_Final_Project/EE_140_240A_Sp25_DigitalTop/schematic
subckt EE_140_240A_Sp25_DigitalTop_schematic CLK CLK_ADC CLK_PGA1 CLK_PGA2 COMP DAC\<7\> DAC\<6\> DAC\<5\> DAC\<4\> DAC\<3\> DAC\<2\> DAC\<1\> DAC\<0\> DONE ENABLE VDD VSS
    X_PGACLKGEN (CLK_PGA CLK_PGA1 CLK_PGA2 VDD VSS) clk_nonoverlapping_schematic
    I6 (net12 RESETB_BUF VDD VSS) invr_dupe_schematic GT_PDW=420n GT_PDL=180.00n sx=4.8e-07 lc=2.7e-07 GT_PUW=720n GT_PUL=180.00n
    I5 (RESETB net12 VDD VSS) invr_dupe_schematic GT_PDW=420n GT_PDL=180.00n sx=4.8e-07 lc=2.7e-07 GT_PUW=720n GT_PUL=180.00n
    X_SAR (CLK_ADC COMP DAC\<7\> DAC\<6\> DAC\<5\> DAC\<4\> DAC\<3\> DAC\<2\> DAC\<1\> DAC\<0\> RESETB_BUF DONE VDD VSS) SAR_DFF_schematic
    X_FSM (VDD VSS CONVERT DONE RESETB CLK CLK_ADC CLK_PGA ENABLE) SAR_FSM_HW_schematic
ends EE_140_240A_Sp25_DigitalTop_schematic

// Test_EE_140_240A_Final_Project/EE_140_240A_Sp25_System/schematic
X_STUDENT (CLK_ADC CLK_PGA1 CLK_PGA2 COMP D\<7\> D\<6\> D\<5\> D\<4\> D\<3\> D\<2\> D\<1\> D\<0\> EXT_IN\<0\> EXT_IN\<1\> G\<2\> G\<1\> G\<0\> S\<1\> S\<0\> VBAT VBATDIV4 VDAC VDDA VDDD VPTAT 0) EE_140_240A_Sp25_Student_Submission_schematic
V4 (VDDD_IDEAL 0) vsource type=pulse edgetype=halfsine val0=0 val1=VDDD_IDEAL delay=0 rise=TR_D
V1 (CLK 0) vsource type=pulse edgetype=halfsine val0=0 val1=1.8 period=1/FCLK rise=10n fall=10n width=.5/FCLK
V3 (net8 0) vsource type=pulse edgetype=halfsine val0=0 val1=NBAT*VBAT rise=TRISE_BAT
I22 (VDDD 0) isource type=pulse val0=1m val1=5m period=100n delay=10n rise=10n fall=10n width=30n
E12 (B\<3\> 0 D\<3\> V0P5) vcvs gain=2 type=vcvs min=0 max=1
E11 (B\<1\> 0 D\<1\> V0P5) vcvs gain=2 type=vcvs min=0 max=1
E10 (B\<0\> 0 D\<0\> V0P5) vcvs gain=2 type=vcvs min=0 max=1
E9 (B\<2\> 0 D\<2\> V0P5) vcvs gain=2 type=vcvs min=0 max=1
E8 (B\<5\> 0 D\<5\> V0P5) vcvs gain=2 type=vcvs min=0 max=1
E7 (B\<4\> 0 D\<4\> V0P5) vcvs gain=2 type=vcvs min=0 max=1
E6 (B\<6\> 0 D\<6\> V0P5) vcvs gain=2 type=vcvs min=0 max=1
E5 (B\<7\> 0 D\<7\> V0P5) vcvs gain=2 type=vcvs min=0 max=1
E4 (G\<2\> 0 VDDD 0) vcvs gain=G_2
E2 (G\<0\> 0 VDDD 0) vcvs gain=G_0
E3 (G\<1\> 0 VDDD 0) vcvs gain=G_1
E0 (S\<1\> 0 VDDD 0) vcvs gain=S_1 type=vcvs
E1 (S\<0\> 0 VDDD 0) vcvs gain=S_0
R0 (VBAT net8) resistor r=NBAT
C0 (VDDD 0) capacitor c=1n
V0 (EXT_IN\<1\> 0) vsource dc=VIN_1 type=dc
V2 (EXT_IN\<0\> 0) vsource dc=VIN_0 type=dc
V5 (V0P5 0) vsource dc=500.0m type=dc
X_GSI (CLK CLK_ADC CLK_PGA1 CLK_PGA2 COMP D\<7\> D\<6\> D\<5\> D\<4\> D\<3\> D\<2\> D\<1\> D\<0\> DONE VDDA VDDA 0) EE_140_240A_Sp25_DigitalTop_schematic
simulatorOptions options temp=27 compatible=spice2
tran tran stop=_EXPR_7 errpreset=conservative
save X_STUDENT.VREF_REG X_STUDENT.PGA_OUT X_STUDENT.MUX_OUT VDDD VDDA VBATDIV4 EXT_IN\<0\> D\<7\> D\<6\> D\<5\> D\<4\> D\<3\> D\<2\> D\<1\> D\<0\> COMP CLK_PGA2 CLK_ADC B\<7\> B\<6\> B\<5\> B\<4\> B\<3\> B\<2\> B\<1\> B\<0\> X_GSI.RESETB_BUF X_STUDENT.VREF_ADC VDAC
saveOptions options save=selected currents=selected
